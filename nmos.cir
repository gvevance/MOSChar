NMOS characterisation

*************************************
* Include model file
*************************************
.include 130nm_bulk.pm

*************************************
* Defining arameters
*************************************
.param len = 0.13u
.param width = 1.3u
.param lmin = 0.13u

*************************************
* Circuit definition
*************************************
vgs 1 0 dc 0.5
M1 1 1 0 0 nmos l={len} w={width} as={2*lmin*width} ad={2*lmin*width} ps={4*lmin+2*width} pd={4*lmin+2*width}

*************************************
* Control section
*************************************

.control

save @M1[id], @M1[igs], @M1[vdsat], @M1[vth0], @M1[cgs], @M1[cgg], @M1[cds] ,
+ @M1[cdd], @M1[gm], @M1[gds], @M1[gmbs], @M1[vsat]

* DC sweep
dc vgs 0 1.3 0.01

* Run the sim
run

* Plot commands
plot @M1[id]
plot @M1[igs]
plot @M1[gm]

.endc

*************************************
* End of file
*************************************
.end
